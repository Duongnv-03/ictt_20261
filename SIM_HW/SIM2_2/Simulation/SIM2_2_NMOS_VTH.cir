SIM2.2 NMOS 035 threshold calibration at VDS=1 V
.include "5827_035.lib"
VDS D 0 1
VGS1 G1 0 1.036
VGS2 G2 0 1.018
VGS3 G3 0 1.006
VGS4 G4 0 1.002
VGS5 G5 0 1.000
M1 D G1 0 0 NM L=1u W=10u AD=20p AS=20p PD=24u PS=24u
M2 D G2 0 0 NM L=2u W=20u AD=40p AS=40p PD=44u PS=44u
M3 D G3 0 0 NM L=5u W=50u AD=100p AS=100p PD=104u PS=104u
M4 D G4 0 0 NM L=10u W=100u AD=200p AS=200p PD=204u PS=204u
M5 D G5 0 0 NM L=20u W=200u AD=400p AS=400p PD=404u PS=404u
.option logopinfo
.op
.end
